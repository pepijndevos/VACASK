* Native callers pass geometry expressions into this foreign model wrapper.
.subckt nboundary d g s b l=2.8e-7 w=2.2e-7 nf=1
M0 d g s b nboundary_model l={l} w={w} nf={nf}
.model nboundary_model.1 nmos level=54 lmin=2.2e-7 lmax=4.4e-7 wmin=2.2e-7 wmax=4.4e-7 vth0=0.35
.model nboundary_model.2 nmos level=54 lmin=2.2e-7 lmax=4.4e-7 wmin=4.4e-7 wmax=8.8e-7 vth0=0.95
.model nboundary_model.3 nmos level=54 lmin=4.4e-7 lmax=8.8e-7 wmin=2.2e-7 wmax=4.4e-7 vth0=0.95
.ends
