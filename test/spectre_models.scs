simulator lang=spectre
model res resistor
model cap capacitor
